* Buck BJT converter — matches digiTS buckbjt circuit exactly
* 10kHz square wave -> push-pull BJT buffer -> NMOS switch -> LC filter -> load
* Drive signal: unipolar 0V to 4.984V square wave (matches digiTS dcOffset mode)

* Model params match digiTS models exactly
* NPN/PNP: BF=100, IS=1e-14, NF=1, BR=1, NR=1, VAF=0(inf), IKF=0(inf), ISE=0, ISC=0
* NMOS 2N7000: VTO=2.236, KP=0.0932174, LAMBDA=0, W=1e-6, L=1e-6
* Diode: IS=1e-14, N=1

.model NPNMOD NPN(BF=100 IS=1e-14 NF=1 BR=1 NR=1 VAF=0 IKF=0 IKR=0 ISE=0 ISC=0)
.model PNPMOD PNP(BF=100 IS=1e-14 NF=1 BR=1 NR=1 VAF=0 IKF=0 IKR=0 ISE=0 ISC=0)
.model N2N7000 NMOS(VTO=2.236 KP=0.0932174 LAMBDA=0 W=1e-6 L=1e-6 PHI=0.6 GAMMA=0)
.model DMOD D(IS=1e-14 N=1)

* Power supplies
Vdc  vcc 0 10
* Unipolar square wave 0V to 4.984V, 10kHz, 50% duty
Vac  drv 0 PULSE(0 4.983907855756475 0 1n 1n 50u 100u)

* NPN driver with collector current sense
Rb1  drv  base_npn 1k
Q1   col_npn_int base_npn 0 NPNMOD
Vic_npn col_npn col_npn_int 0
R1   vcc col_npn 10k

* PNP driver with collector current sense
Rb2  drv  base_pnp 1k
Q2   col_pnp_int base_pnp vcc PNPMOD
Vic_pnp col_pnp col_pnp_int 0
R2   col_pnp 0 10k

* NMOS switch (2N7000): gate = col_npn (NDRV net), drain = VCC, source = switch_node
M1   vcc col_npn sw sw N2N7000

* Freewheeling diode with current sense
Vdiode diode_a 0 0
D1   diode_a sw DMOD

* LC filter: L1 = 0.3H, C1 = 10uF
L1   sw out 0.3
C1   out 0 10u

* Load resistor: 50 ohm
Rload out 0 50

.tran 1u 500m

.control
tran 1u 500m

* === Phase 1: BJT driver at 1.025ms (1/4 through cycle — drive high) ===
meas tran vcol_npn_hi FIND v(col_npn) AT=1.025m
meas tran vcol_pnp_hi FIND v(col_pnp) AT=1.025m
meas tran ic_npn_hi FIND i(Vic_npn) AT=1.025m
meas tran ic_pnp_hi FIND i(Vic_pnp) AT=1.025m

* === Phase 1b: BJT driver at 1.075ms (3/4 through cycle — drive low) ===
meas tran vcol_npn_lo FIND v(col_npn) AT=1.075m
meas tran vcol_pnp_lo FIND v(col_pnp) AT=1.075m
meas tran ic_npn_lo FIND i(Vic_npn) AT=1.075m
meas tran ic_pnp_lo FIND i(Vic_pnp) AT=1.075m

* === Phase 2: Steady state — last 2 cycles (499.8ms to 500ms) ===
* Switch node
meas tran vsw_min MIN v(sw) FROM=499.8m TO=500m
meas tran vsw_max MAX v(sw) FROM=499.8m TO=500m
meas tran vsw_mean AVG v(sw) FROM=499.8m TO=500m

* Output
meas tran vout_min MIN v(out) FROM=499.8m TO=500m
meas tran vout_max MAX v(out) FROM=499.8m TO=500m
meas tran vout_mean AVG v(out) FROM=499.8m TO=500m

* Diode current
meas tran idiode_min MIN i(Vdiode) FROM=499.8m TO=500m
meas tran idiode_max MAX i(Vdiode) FROM=499.8m TO=500m
meas tran idiode_mean AVG i(Vdiode) FROM=499.8m TO=500m

* NPN/PNP collector voltages at steady state
meas tran vcol_npn_min MIN v(col_npn) FROM=499.8m TO=500m
meas tran vcol_npn_max MAX v(col_npn) FROM=499.8m TO=500m
meas tran vcol_pnp_min MIN v(col_pnp) FROM=499.8m TO=500m
meas tran vcol_pnp_max MAX v(col_pnp) FROM=499.8m TO=500m

* NPN/PNP collector currents at steady state
meas tran ic_npn_min MIN i(Vic_npn) FROM=499.8m TO=500m
meas tran ic_npn_max MAX i(Vic_npn) FROM=499.8m TO=500m
meas tran ic_pnp_min MIN i(Vic_pnp) FROM=499.8m TO=500m
meas tran ic_pnp_max MAX i(Vic_pnp) FROM=499.8m TO=500m

quit
.endc
.end
