Pin Loading Unloaded
Vs vs 0 5
R1 vs div 10k
R2 div 0 10k
.op
.end
