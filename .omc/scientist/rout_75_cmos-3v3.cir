rOut Override 75ohm
Voh source 0 3.3
Rout source junction 75
Rload junction 0 10k
.op
.end
