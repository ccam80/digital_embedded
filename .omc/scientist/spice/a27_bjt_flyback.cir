BJT Switch Flyback Diode
Vcc 1 0 DC 12
Vin 4 0 DC 3
L1 1 3 1m
D1 3 1 D1N4148
Rb 4 5 1k
Q1 3 5 0 QNPN
.model QNPN NPN(BF=100 VAF=100 IS=1e-14 RB=10)
.model D1N4148 D(IS=2.52e-9 RS=0.568 N=1.752 CJO=4e-12 M=0.4 VJ=0.8 BV=100)
.tran 500n 500u
.meas tran v_probe_on FIND V(3) AT=490u
.meas tran il_on      FIND I(L1) AT=490u
.end
