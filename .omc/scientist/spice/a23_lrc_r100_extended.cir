LRC Switch R=100 extended
Vs 1 0 DC 5
SW 1 2 ctrl 0 MYSW
Vctrl ctrl 0 PULSE(0 1 10u 1n 1n 1 2)
L1 2 3 1m IC=0
R1 3 4 100
C1 4 0 1u IC=0
.model MYSW SW(Ron=0.001 Roff=1Meg Vt=0.5)
.tran 0.5u 1m UIC
.meas tran vc_max      MAX V(4)
.meas tran t_vc_max    WHEN V(4)=4.977 RISE=1
.meas tran vc_at_tau1  FIND V(4) AT=98.7u
.meas tran vc_final    FIND V(4) AT=990u
.end
