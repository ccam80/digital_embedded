* Op-amp Integrator  Vin=1V R1=10k Cf=1uF
* Slew rate = -Vin/(R*C) = -1/(10k*1u) = -100 V/s
Vin   in   0   DC 1
R1    in   inv 10k
Cf    inv  out 1u
* ideal op-amp: Eoa gain=1e6
Eoa   out  0   0   inv  1e6
* .ic sets initial Vcf=0
.ic V(out)=0 V(inv)=0
.tran 0.1ms 10ms uic
.print tran V(out) V(inv)
.end
