* 555 Astable - proper behavioral with SR latch
* Vcc=5V Ra=1k Rb=10k C=1uF
Vcc   vcc  0   DC 5

* Timing network
Ra    vcc   nd1   1k
Rb    nd1   nc    10k
C1    nc    0     1u   IC=1.5

* Discharge: when Q_bar (qbar) is LOW (output HIGH), dis is open
* when Q_bar is HIGH (output LOW), dis connects nd1 to 0
Rdis  nd1   ndis  1
Sdis  ndis  0     qbar  0  SWD
.model SWD SW(VT=2.5 VH=0.1 RON=10 ROFF=100Meg)

* Comparator 1: SET when Vcap < Vcc/3 => sets Q=1 (output HIGH)
* Comparator 2: RESET when Vcap > 2*Vcc/3 => sets Q=0 (output LOW)
* SR latch using behavioral sources
* S = (Vcap < Vcc/3), R = (Vcap > 2*Vcc/3)
* Q_{n+1} = S | (Q_n & ~R)

* Use voltage state variable for Q
* Implemented as: Q' = if S then 1 elif R then 0 else Q
Bq    q    0   V = ( V(nc) < 1.6667 ? 5 : ( V(nc) > 3.3333 ? 0 : V(q) ) )
Bqbar qbar 0   V = 5 - V(q)
Bout  out  0   V = V(q)

.tran 0.05ms 90ms uic
.print tran V(out) V(nc)
.end
