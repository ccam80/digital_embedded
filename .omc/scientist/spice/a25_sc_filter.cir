Switched Capacitor Filter simplified
* CLK 50% duty 10kHz
* Vin -> S1 -> node_A (C1 to GND, S2 to node_B)
* node_B: C2 to GND, R1 to OA:in-
* OA: in+ = GND, simple unity gain
Vdd 1 0 DC 5
Vin 2 0 DC 2
Vclk g 0 PULSE(0 1 0 10n 10n 50u 100u)
S1 2 3 g 0 MYSW
S2 3 4 g 0 MYSW
C1 3 0 1n IC=0
C2 4 0 1n IC=0
R1 4 5 1k
* Ideal OpAmp: Vout = Vin+ - Vin- = 0 - V(5) = -V(5)
* Model as VCVS buffer: Vout = -V(5)
E1 6 0 0 5 1e5
R_oa 5 6 1Meg
.model MYSW SW(Ron=0.001 Roff=1Meg Vt=0.5)
.tran 1u 20m UIC
.meas tran v4_avg  AVG V(4) FROM=10m TO=20m
.meas tran v4_pp   PP  V(4) FROM=10m TO=20m
.meas tran vout_avg AVG V(6) FROM=10m TO=20m
.end
