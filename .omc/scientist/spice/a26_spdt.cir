SPDT Source Selector
* V1=3V connects during 0-5ms, V2=8V during 5-10ms
V1 1 0 DC 3
V2 2 0 DC 8
SW1 1 3 ctrl1 0 MYSW
SW2 2 3 ctrl2 0 MYSW
Vctrl1 ctrl1 0 PULSE(1 0 5m 1n 1n 10 20)
Vctrl2 ctrl2 0 PULSE(0 1 5m 1n 1n 10 20)
R1 3 4 1k
C1 4 0 1u IC=0
.model MYSW SW(Ron=0.001 Roff=1Meg Vt=0.5)
.tran 100u 12m UIC
.meas tran vc_v1_ss    FIND V(4) AT=4.9m
.meas tran vc_after_sw FIND V(4) AT=5.1m
.meas tran vc_at_tau2  FIND V(4) AT=6.0m
.meas tran vc_v2_ss    FIND V(4) AT=11.9m
.end
