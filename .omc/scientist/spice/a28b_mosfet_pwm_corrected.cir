MOSFET PWM correct topology
* Vdd->M1:D, CLK->M1:G, M1:S->L1->R1->C1->GND
Vdd 1 0 DC 12
Vgate g 0 PULSE(0 12 0 10n 10n 50u 100u)
M1 1 g 2 0 NMOS
L1 2 3 1m
R1 3 4 100
C1 4 0 1u IC=0
.model NMOS NMOS(VTO=2 KP=1 LAMBDA=0)
.tran 5u 30m UIC
.meas tran vout_avg AVG V(4) FROM=20m TO=30m
.meas tran vout_pp  PP  V(4) FROM=20m TO=30m
.meas tran vs_avg   AVG V(2) FROM=20m TO=30m
.end
