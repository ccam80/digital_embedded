LRC Switch R=1k (very overdamped)
Vs 1 0 DC 5
SW 1 2 ctrl 0 MYSW
Vctrl ctrl 0 PULSE(0 1 10u 1n 1n 10m 20m)
L1 2 3 1m IC=0
R1 3 4 1k
C1 4 0 1u IC=0
.model MYSW SW(Ron=0.001 Roff=1Meg Vt=0.5)
.tran 1u 10m UIC
.meas tran vc_max    MAX V(4)
.meas tran vc_final  FIND V(4) AT=9.9m
.end
