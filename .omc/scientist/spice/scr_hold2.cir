* SCR 2BJT with holding cap - no current probe
Vcc    vcc   0    DC 12
R1     vcc   a    1k
Chold  a     0    1n
Vgate  g     0    PULSE(0 5 0.5ms 0.01ms 0.01ms 0.3ms 100ms)
Q1     0     nd1   a    PMOD
.model PMOD PNP(BF=100 IS=1e-12 TF=10n TR=100n CJE=5p CJC=3p)
Q2     nd1   g     0    NMOD
.model NMOD NPN(BF=100 IS=1e-12 TF=10n TR=100n CJE=5p CJC=3p)
Rsnub  a   0   1Meg
.tran 0.01ms 3ms
.print tran V(a) V(g)
.end
