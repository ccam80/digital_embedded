* SCR behavioral model: fires when Vg>0.7V and V(a)>1V, then stays on
* State variable: 'state' = 0 (off) or 5 (on)
* Once fired, stays on until Ia drops below IH
Vcc    vcc   0    DC 12
R1     vcc   a    1k
Rgate  gsrc  g    1k
Vgate  gsrc  0    PULSE(0 3 0.5ms 0.01ms 0.01ms 0.3ms 100ms)
* Fire condition: gate current > IGT (V(g) > ~0.7V) AND V(a) > 1V
* Once fired, stay on until V(a) < ~0.1V (latch releases)
* State node: 'st' = 5V when latched, 0V when off
Bst  st  0  V = ( (V(g) > 0.7 && V(a) > 1.0) ? 5 : (V(st) > 2.5 && V(a) > 0.5 ? 5 : 0) )
* SCR resistance: very high when off, low (10ohm) when on
Rscr   a   0   Rbig
.param Rbig=10Meg
* Actually use a switch controlled by state
Rscr2  a   nd_k  10
Sscr   nd_k  0   st  0   SWSCR
.model SWSCR SW(VT=2.5 VH=0.1 RON=1 ROFF=10Meg)
.tran 0.02ms 3ms
.print tran V(a) V(g) V(st)
.end
