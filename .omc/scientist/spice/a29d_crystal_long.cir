Crystal Oscillator long run
Vcc 1 0 DC 5
Rc 1 2 4.7k
Rb 1 3 1Meg
Q1 2 3 4 QNPN
Rs 2 5 10
Ls 5 6 10m IC=1m
Cs 6 3 2.5p
Cp 2 3 5p
C1 4 0 10n IC=0.01
C2 3 0 10n IC=0.001
.model QNPN NPN(BF=100 VAF=100 IS=1e-14 RB=100)
.tran 50n 5m UIC
.meas tran vb_pp_early  PP  V(3) FROM=0.5m TO=1m
.meas tran vb_pp_mid    PP  V(3) FROM=2m TO=2.5m
.meas tran vb_pp_late   PP  V(3) FROM=4m TO=5m
.meas tran vc_pp_late   PP  V(2) FROM=4m TO=5m
.end
