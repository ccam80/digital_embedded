MOSFET PWM into RLC filter
Vdd 1 0 DC 12
Vgate g 0 PULSE(0 12 0 10n 10n 50u 100u)
M1 1 g 2 2 NMOS
L1 2 3 1m
R1 3 4 100
C1 4 0 1u IC=0
.model NMOS NMOS(VTO=2 KP=1 LAMBDA=0)
.tran 5u 20m UIC
.meas tran vout_avg AVG V(4) FROM=10m TO=20m
.meas tran vout_pp  PP  V(4) FROM=10m TO=20m
.meas tran vout_max MAX V(4) FROM=10m TO=20m
.end
