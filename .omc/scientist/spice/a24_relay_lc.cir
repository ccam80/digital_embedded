Relay-driven LC
Vcoil 1 0 DC 5
Vsig 2 0 DC 5
SW_coil 1 0 ctrl 0 MYRELAY
Vctrl ctrl 0 PULSE(0 1 5u 1n 1n 10m 20m)
SW_contact 2 3 ctrl 0 MYCONTACT
L1 3 4 1m IC=0
C1 4 0 1u IC=0
R1 3 0 1k
.model MYRELAY SW(Ron=100 Roff=1Meg Vt=0.5)
.model MYCONTACT SW(Ron=0.1 Roff=1Meg Vt=0.5)
.tran 1u 1m UIC
.meas tran v3_max   MAX V(3)
.meas tran v3_at5u  FIND V(3) AT=5u
.meas tran v3_at100u FIND V(3) AT=105u
.meas tran v3_at500u FIND V(3) AT=505u
.end
