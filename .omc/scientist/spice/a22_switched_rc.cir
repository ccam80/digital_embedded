Switched RC Charge
Vs 1 0 DC 5
SW 1 2 ctrl 0 MYSW
Vctrl ctrl 0 PULSE(0 1 50u 1n 1n 10m 20m)
R1 2 3 1k
C1 3 0 1u IC=0
.model MYSW SW(Ron=1 Roff=1Meg Vt=0.5)
.tran 50u 8m UIC
.meas tran vc_open    FIND V(3) AT=40u
.meas tran vc_at_tau  FIND V(3) AT=1050u
.meas tran vc_at_5tau FIND V(3) AT=5050u
.meas tran vc_final   FIND V(3) AT=7.9m
.end
