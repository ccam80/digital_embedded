* Triac dimmer: 60Hz, R1=100k, C1=0.1u, Rload=100
* Diac VBO=32V, Triac modeled as SCR pair
Vs    in  0  SIN(0 170 60)
* Phase control: R1-C1 network
R1    in  rc_nd  100k
C1    rc_nd  0   100n  IC=0
* Diac: bidirectional breakover at 32V
* Model as B-source: triggers gate when |V(rc_nd)| > 32V
Bgtr  gate  0  V = ( V(rc_nd) > 32 ? 5 : ( V(rc_nd) < -32 ? -5 : 0 ) )
* Triac as bidirectional switch controlled by gate
* Use two switches: one for positive, one for negative half
Sp    in    load  gate  0  SWPOS
.model SWPOS SW(VT=2.5 VH=0.1 RON=1 ROFF=100Meg)
Sn    load  in    neg_gate  0  SWNEG
.model SWNEG SW(VT=2.5 VH=0.1 RON=1 ROFF=100Meg)
Bneg  neg_gate  0  V = -V(gate)
* Load
Rload load  0  100
.tran 0.05ms 50ms
.print tran V(load) V(rc_nd) V(in)
.end
