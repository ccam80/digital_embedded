Crystal Oscillator Colpitts
Vcc 1 0 DC 5
Rc 1 2 4.7k
Rb 1 3 1Meg
Q1 2 3 4 QNPN
* Crystal between collector(2) and base(3): series RLC + parallel Cp
Rs 2 5 10
Ls 5 6 10m
Cs 6 3 2.5p
Cp 2 3 5p
C1 4 0 10n IC=0.01
C2 3 0 10n IC=0
.model QNPN NPN(BF=100 VAF=100 IS=1e-14 RB=100)
.tran 50n 200u
.meas tran vc_pp  PP  V(2) FROM=100u TO=200u
.meas tran vc_max MAX V(2) FROM=100u TO=200u
.meas tran vc_min MIN V(2) FROM=100u TO=200u
.end
