* Op-amp Inverting Amplifier  Vin=1V Rin=1k Rf=10k
Vin   in   0   DC 1
Rin   in   inv 1k
Rf    inv  out 10k
Eoa   out  0   0   inv  1e6
.op
.measure oppoint v_output FIND V(out) AT=0
.measure oppoint v_inv    FIND V(inv) AT=0
.measure oppoint v_in     FIND V(in)  AT=0
.end
