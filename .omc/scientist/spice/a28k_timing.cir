Buck timing check
Vdd 1 0 DC 12
Vgate g 0 PULSE(0 5 0 10n 10n 50u 100u)
SW1 1 2 g 0 MYSW
D1 0 2 DFAST
L1 2 3 1m
R1 3 4 100
C1 4 0 1u IC=0
.model MYSW SW(Ron=0.001 Roff=100Meg Vt=2.5)
.model DFAST D(IS=1e-9 N=1 RS=0.01)
.tran 2u 50m UIC
.meas tran vc_1ms   FIND V(4) AT=1m
.meas tran vc_5ms   FIND V(4) AT=5m
.meas tran vc_10ms  FIND V(4) AT=10m
.meas tran vc_20ms  FIND V(4) AT=20m
.meas tran vc_30ms  FIND V(4) AT=30m
.end
