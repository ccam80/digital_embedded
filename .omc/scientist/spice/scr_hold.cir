* SCR 2BJT with holding cap
Vcc    vcc   0    DC 12
R1     vcc   a    1k
* Small cap helps holding current charge-pump
Chold  a     0    1n
* Direct gate: 5V pulse at 0.5ms for 0.3ms
Vgate  g     0    PULSE(0 5 0.5ms 0.01ms 0.01ms 0.3ms 100ms)
* PNP: emitter=a, base=nd1, collector=k=0
Q1     0     nd1   a    PMOD
.model PMOD PNP(BF=100 IS=1e-12 TF=10n TR=100n CJE=5p CJC=3p)
* NPN: collector=nd1, base=g, emitter=0
Q2     nd1   g     0    NMOD
.model NMOD NPN(BF=100 IS=1e-12 TF=10n TR=100n CJE=5p CJC=3p)
Rsnub  a   0   1Meg
.tran 0.01ms 3ms
.print tran V(a) V(g) I(R1)
.end
