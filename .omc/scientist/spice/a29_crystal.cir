Crystal Oscillator Colpitts
* Vcc=5V, Rc=4.7k, Rb=1M, crystal as series RLC
* Crystal: f_series ~= 1MHz, L_s=10mH, C_s=2.5pF, R_s=10ohm, C_p=5pF
* Colpitts: C1=10nF, C2=10nF (load capacitors)
* Q1 NPN
Vcc 1 0 DC 5
Rc 1 2 4.7k
Rb 1 3 1Meg
Q1 2 3 4 QNPN
X1 2 3 XTAL
C1 4 0 10n IC=0.01
C2 3 0 10n IC=0
.subckt XTAL A B
* Series RLC model of crystal at ~1MHz
Rs 1 2 10
Ls 2 3 10m
Cs 3 4 2.5p
Cp 1 4 5p
Rp 1 4 100Meg
.connect 1 A
.connect 4 B
.ends XTAL
.model QNPN NPN(BF=100 VAF=100 IS=1e-14 RB=100)
.tran 50n 100u
.meas tran vc_max MAX V(2) FROM=50u TO=100u
.meas tran vc_min MIN V(2) FROM=50u TO=100u
.meas tran vc_pp  PP  V(2) FROM=50u TO=100u
.end
