* SCR 2BJT - debug gate drive
Vcc    vcc   0    DC 12
R1     vcc   a    1k
* Direct gate drive (no Rg for now)
Vgate  g     0    PULSE(0 5 0.5ms 0.01ms 0.01ms 0.3ms 100ms)
Q1     0     nd1   a    PMOD
.model PMOD PNP(BF=100 IS=1e-12)
Q2     nd1   g     0    NMOD
.model NMOD NPN(BF=100 IS=1e-12)
Rsnub  a   0   1Meg
.tran 0.02ms 3ms
.print tran V(a) V(g)
.end
