* SCR forced ON state: model as 2xVbe diode stack
Vcc  vcc  0  DC 12
R1   vcc  a  1k
* Two diodes in series (PNP emitter-base + NPN base-emitter)
D1  a   nd1  DMOD
D2  nd1  0   DMOD
.model DMOD D(IS=1e-12 N=1 RS=1)
.op
.end
