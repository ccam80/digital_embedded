Buck debug toggle
Vdd 1 0 DC 12
Vgate g 0 PULSE(0 5 0 10n 10n 50u 100u)
SW1 1 2 g 0 MYSW
R1 2 0 1k
.model MYSW SW(Ron=0.001 Roff=100Meg Vt=2.5)
.tran 1u 200u
.meas tran v2_25u FIND V(2) AT=25u
.meas tran v2_75u FIND V(2) AT=75u
.end
