rOut Override default(50)
Voh source 0 5.0
Rout source junction 50
Rload junction 0 10k
.op
.end
