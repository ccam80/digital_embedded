Master3 DC - DAC into RC
Vdac dac_int 0 3.125
Rdac dac_int rc_node 100
R1 rc_node cap_pos 1k
C1 cap_pos 0 1u IC=0
* Vref2 for comparator reference
Vref2 vref2 0 2.5
* Vref source (just for measurement)
Vref vref 0 5.0

.tran 1u 5m UIC
.print tran v(vref) v(rc_node) v(cap_pos) v(vref2)
.end
