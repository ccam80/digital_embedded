M3 DC at 10ms
Vdac dac_int 0 3.125
Rdac dac_int rc_node 100
R1 rc_node cap_pos 1k
C1 cap_pos 0 1u IC=0
Vref vref 0 5.0
Vref2 vref2 0 2.5
.tran 1u 10m UIC
.measure tran v_vref FIND v(vref) AT=5m
.measure tran v_rc_5ms FIND v(rc_node) AT=5m
.measure tran v_cap_5ms FIND v(cap_pos) AT=5m
.measure tran v_rc_10ms FIND v(rc_node) AT=10m
.measure tran v_cap_10ms FIND v(cap_pos) AT=10m
.measure tran v_vref2 FIND v(vref2) AT=5m
.end
