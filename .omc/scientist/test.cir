Test Circuit
V1 1 0 5
R1 1 0 1k
.op
.end
