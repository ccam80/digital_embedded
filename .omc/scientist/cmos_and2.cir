CMOS AND2 Gate
.model nmod nmos (VTO=1.0 KP=2e-5 LAMBDA=0.01)
.model pmod pmos (VTO=-1.0 KP=1e-5 LAMBDA=0.01)
VDD vdd 0 5
VA1 in1h 0 5
VB1 in2h 0 5
Mp1h vdd in1h nandh vdd pmod W=1u L=1u
Mp2h vdd in2h nandh vdd pmod W=1u L=1u
Mn1h nandh in1h serh 0 nmod W=1u L=1u
Mn2h serh in2h 0 0 nmod W=1u L=1u
MpIh vdd nandh outh vdd pmod W=1u L=1u
MnIh outh nandh 0 0 nmod W=1u L=1u
VA2 in1l 0 5
VB2 in2l 0 0
Mp1l vdd in1l nandl vdd pmod W=1u L=1u
Mp2l vdd in2l nandl vdd pmod W=1u L=1u
Mn1l nandl in1l serl 0 nmod W=1u L=1u
Mn2l serl in2l 0 0 nmod W=1u L=1u
MpIl vdd nandl outl vdd pmod W=1u L=1u
MnIl outl nandl 0 0 nmod W=1u L=1u
VA3 in1z 0 0
VB3 in2z 0 0
Mp1z vdd in1z nandz vdd pmod W=1u L=1u
Mp2z vdd in2z nandz vdd pmod W=1u L=1u
Mn1z nandz in1z serz 0 nmod W=1u L=1u
Mn2z serz in2z 0 0 nmod W=1u L=1u
MpIz vdd nandz outz vdd pmod W=1u L=1u
MnIz outz nandz 0 0 nmod W=1u L=1u
.op
.end
